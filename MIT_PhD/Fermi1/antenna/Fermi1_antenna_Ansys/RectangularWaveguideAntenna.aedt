# Ansys Electronics Desktop project, version 2022.2
materials:
  vacuum: permittivity=1
  copper: permeability=0.999991 conductivity=58000000
  glass_PTFEreinf: permittivity=2.5 dielectric_loss_tangent=0.002
  pec: conductivity=1e+30

design HFSSDesign2 (HFSS, DrivenModal, model units mm)
variables:
  width = 33mm
  height = 33mm
  length = 58mm  # optimise 32.5mm..97.5mm
  wallthickness = 1mm
  MOTbeamD = (25.4/2) mm
  backshort = 13mm
  sma_outer_d = 4.6mm
  sma_innerD = 1.27mm
  probe_length = 11mm
geometry:
  backplate = box(corner=(-width/2, -height/2, 0mm), size=(width, height, wallthickness))
  MOTbeam = cylinder(axis=Z, base_centre=(0mm, 0mm, 0mm), radius=MOTbeamD/2, height=wallthickness)
  backplate.subtract(MOTbeam)
  waveguide_vacuum = box(corner=(-width/2, -height/2, 0mm), size=(width, height, length))
  waveguide_body [copper] = box(corner=(-width/2-wallthickness, -height/2-wallthickness, 0mm), size=(width+2*wallthickness, height+2*wallthickness, length))
  waveguide_body.subtract(waveguide_vacuum)
  waveguide_body.unite(backplate)
  coordinate_system RelativeCS1 = origin=(height/2, 0mm, backshort) x=(1mm, 0mm, 0mm) y=(0mm, 1mm, 0mm)
  sma_port_1 = cylinder(axis=X, base_centre=(0mm, 0mm, 0mm), radius=sma_outer_d/2, height=2mm) in RelativeCS1
  waveguide_body.subtract(sma_port_1)
  sma_port_connector_1 [pec] = cylinder(axis=X, base_centre=(0mm, 0mm, 0mm), radius=sma_outer_d/2, height=wallthickness+5.0mm) in RelativeCS1
  sma_dieletric [glass_PTFEreinf] = cylinder(axis=X, base_centre=(0mm, 0mm, 0mm), radius=sma_outer_d/2-0.5 mm, height=wallthickness+5.0mm) in RelativeCS1
  sma_dieletric_1 = sma_dieletric.copy()
  sma_port_connector_1.subtract(sma_dieletric_1)
  sma_inner_conductor [pec] = cylinder(axis=X, base_centre=(-probe_length, 0mm, 0mm), radius=sma_innerD/2, height=wallthickness+5.0mm+probe_length) in RelativeCS1
  sma_inner_conductor_1 = sma_inner_conductor.copy()
  sma_dieletric.subtract(sma_inner_conductor_1)
  Air [vacuum] = box(corner=(-width/2, -height/2, 0mm), size=(width, height, length))
  radiation_box [vacuum] = box(corner=(-50mm, -50mm, -10mm), size=(100mm, 100mm, 100mm))
  pecCap1 [pec] = object_from(sma_dieletric.edge(2 of 2))
  pecCap1.thicken(0.5mm)
  sma_inner_conductor_2 = sma_inner_conductor.copy()
  Air.subtract(sma_inner_conductor_2)
  waveguide_body_1 = waveguide_body.copy()
  Air.subtract(waveguide_body_1)
  sma_dieletric_2 = sma_dieletric.copy()
  waveguide_body.subtract(sma_dieletric_2)
  sma_port_connector_1_1 = sma_port_connector_1.copy()
  waveguide_body.subtract(sma_port_connector_1_1)
  sma_inner_conductor_3 = sma_inner_conductor.copy()
  waveguide_body.subtract(sma_inner_conductor_3)
boundaries and excitations:
  PerfE1: Perfect E Objects=[waveguide_body, sma_port_connector_1, sma_inner_conductor]
  Rad1: Radiation Objects=radiation_box
  1: Wave Port Faces=sma_dieletric.face(3 of 3) NumModes=1 Modes{Mode1{IntLine{(22.5, 1.8, 13) -> (22.5, 0.635, 13)} CharImp=Zpi}}
setups:
  Setup1: HfssDriven Frequency=5.64GHz MaxDeltaS=0.02 MaximumPasses=25 MinimumPasses=1 MinimumConvergedPasses=1 PercentRefinement=30 BasisOrder=1 PortAccuracy=2 DrivenSolverType="Direct Solver"
    sweep Sweep: 4GHz to 7GHz, 301 points; Type=Interpolating InterpTolerance=0.5 InterpMaxSolns=250 InterpUsePortImped=false PassivityErrorTolerance=0.0001
source amplitudes:
  1:1: 1W 0deg
radiation setups:
  Infinite Sphere1: Infinite Sphere Theta=-180deg..180deg step 1deg Phi=0deg..180deg step 1deg
  Box1: Near Box  Length=20mm Width=20mm LengthSamples=21 WidthSamples=21 CoordSystem=Global Height=20mm HeightSamples=21
  Sphere1: Near Sphere Theta=0deg..180deg step 1deg Phi=-180deg..180deg step 1deg Radius=100mm
reports:
  S Parameter Plot 1: dB(S(1,1)) vs Freq on Setup1 : Sweep [length=all wallthickness=1mm backshort=22mm probe_length=13mm]
  S Parameter Plot 2: dB(S(1,1)) vs Freq on Setup1 : Sweep [length=58mm wallthickness=1mm backshort=13mm probe_length=all]
