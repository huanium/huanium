# Ansys Electronics Desktop project, version 2022.2
materials:
  copper: permeability=0.999991 conductivity=58000000
  glass_PTFEreinf: permittivity=2.5 dielectric_loss_tangent=0.002
  pec: conductivity=1e+30
  vacuum: permittivity=1
  steel_stainless: conductivity=1100000

design HFSSDesign2 (HFSS, DrivenModal, model units mm)
variables:
  width = 33mm
  height = 33mm
  length = 58mm  # optimise 32.5mm..97.5mm
  wallthickness = 1mm
  MOTbeamD = (25.4/2) mm
  backshort = 13mm
  sma_outer_d = 4.6mm
  sma_innerD = 1.27mm
  probe_length = 10.5mm
  tableLength = 500mm
  tableDistance = 100mm
  tableThickness = 2mm
  flangethickness = 15mm
  windowthickness = 12mm
  windowR = 40mm
  distanceToSource = 65mm
  vac_innerR = 40mm
  vac_outerR = 50mm
  vacHeight = 20mm
  radBoxX = 150mm
  radBoxY = 150mm
  radBoxZ = 150mm
geometry:
  backplate = box(corner=(-width/2, -height/2, 0mm), size=(width, height, wallthickness))
  MOTbeam = cylinder(axis=Z, base_centre=(0mm, 0mm, 0mm), radius=MOTbeamD/2, height=wallthickness)
  backplate.subtract(MOTbeam)
  waveguide_vacuum = box(corner=(-width/2, -height/2, 0mm), size=(width, height, length))
  waveguide_body [copper] = box(corner=(-width/2-wallthickness, -height/2-wallthickness, 0mm), size=(width+2*wallthickness, height+2*wallthickness, length))
  waveguide_body.subtract(waveguide_vacuum)
  waveguide_body.unite(backplate)
  coordinate_system RelativeCS1 = origin=(height/2, 0mm, backshort) x=(1mm, 0mm, 0mm) y=(0mm, 1mm, 0mm)
  sma_port_1 = cylinder(axis=X, base_centre=(0mm, 0mm, 0mm), radius=sma_outer_d/2, height=2mm) in RelativeCS1
  waveguide_body.subtract(sma_port_1)
  sma_port_connector_1 [pec] = cylinder(axis=X, base_centre=(0mm, 0mm, 0mm), radius=sma_outer_d/2, height=wallthickness+5.0mm) in RelativeCS1
  sma_dieletric [glass_PTFEreinf] = cylinder(axis=X, base_centre=(0mm, 0mm, 0mm), radius=sma_outer_d/2-0.5 mm, height=wallthickness+5.0mm) in RelativeCS1
  sma_dieletric_1 = sma_dieletric.copy()
  sma_port_connector_1.subtract(sma_dieletric_1)
  sma_inner_conductor [pec] = cylinder(axis=X, base_centre=(-probe_length, 0mm, 0mm), radius=sma_innerD/2, height=wallthickness+5.0mm+probe_length) in RelativeCS1
  sma_inner_conductor_1 = sma_inner_conductor.copy()
  sma_dieletric.subtract(sma_inner_conductor_1)
  Air [vacuum] = box(corner=(-width/2, -height/2, 0mm), size=(width, height, length))
  pecCap1 [pec] = object_from(sma_dieletric.edge(2 of 2))
  pecCap1.thicken(0.5mm)
  sma_inner_conductor_2 = sma_inner_conductor.copy()
  Air.subtract(sma_inner_conductor_2)
  waveguide_body_1 = waveguide_body.copy()
  Air.subtract(waveguide_body_1)
  sma_dieletric_2 = sma_dieletric.copy()
  waveguide_body.subtract(sma_dieletric_2)
  sma_port_connector_1_1 = sma_port_connector_1.copy()
  waveguide_body.subtract(sma_port_connector_1_1)
  sma_inner_conductor_3 = sma_inner_conductor.copy()
  waveguide_body.subtract(sma_inner_conductor_3)
  coordinate_system RelativeCS2 = origin=(0, width/2, backshort) x=(1mm, 0mm, 0mm) y=(0mm, 1mm, 0mm)
  Cylinder1 = cylinder(axis=Y, base_centre=(0mm, 0mm, 0mm), radius=sma_outer_d/2, height=wallthickness) in RelativeCS2
  waveguide_body.subtract(Cylinder1)
  sma_port_connector_2 [pec] = cylinder(axis=Y, base_centre=(0mm, 0mm, 0mm), radius=2.3mm, height=wallthickness+5.0mm) in RelativeCS2
  sma_dielectric_2 [glass_PTFEreinf] = cylinder(axis=Y, base_centre=(0mm, 0mm, 0mm), radius=sma_outer_d/2-0.5mm, height=wallthickness+5.0mm) in RelativeCS2
  sma_port_connector_2_1 = sma_port_connector_2.copy()
  waveguide_body.subtract(sma_port_connector_2_1)
  sma_dielectric_2_1 = sma_dielectric_2.copy()
  sma_port_connector_2.subtract(sma_dielectric_2_1)
  sma_inner_conductor_2_1 [pec] = cylinder(axis=Y, base_centre=(0mm, -probe_length, 0mm), radius=sma_innerD/2, height=probe_length+5.0mm+wallthickness) in RelativeCS2
  sma_inner_conductor_2_1_1 = sma_inner_conductor_2_1.copy()
  sma_dielectric_2.subtract(sma_inner_conductor_2_1_1)
  pecCap2 [pec] = object_from(sma_dielectric_2.edge(2 of 2))
  pecCap2.thicken(0.5mm)
  sma_inner_conductor_2_1_2 = sma_inner_conductor_2_1.copy()
  Air.subtract(sma_inner_conductor_2_1_2)
  point Point1 = (0mm, 0mm, 85mm)
  vacuum_chamber_window = rectangle(corner=(0mm, windowR, distanceToSource+windowthickness), y_size=flangethickness, z_size=-windowthickness)
  vacuum_chamber_window.sweep_around_axis(axis=Z, angle=360deg)
  coordinate_system RelativeCS3 = origin=(0mm, 0mm, distanceToSource+windowthickness) x=(1mm, 0mm, 0mm) y=(0mm, 1mm, 0mm)
  vacuum_inner = cylinder(axis=Z, base_centre=(0mm, 0mm, 0mm), radius=vac_innerR, height=vacHeight) in RelativeCS3
  vacuum_outer [steel_stainless] = cylinder(axis=Z, base_centre=(0mm, 0mm, 0mm), radius=vac_outerR, height=vacHeight) in RelativeCS3
  vacuum_outer.subtract(vacuum_inner)
  vacuum_outer.unite(vacuum_chamber_window)
  radiation_box [vacuum] = box(corner=(-radBoxX/2, -radBoxY/2, -25mm), size=(radBoxX, radBoxY, radBoxZ))
  atom_box [vacuum] = box(corner=(-width/2, -height/2, length+25mm), size=(width, height, 1mm))
  point Point2 = (0mm, 0mm, 84mm)
boundaries and excitations:
  PerfE1: Perfect E Objects=[waveguide_body, sma_port_connector_1, sma_inner_conductor]
  PerfE2: Perfect E Objects=vacuum_outer
  Rad1: Radiation Objects=radiation_box
  1: Wave Port Faces=sma_dieletric.face(3 of 3) NumModes=1 Modes{Mode1{IntLine{(22.5, 1.8, 13) -> (22.5, 0.635, 13)} CharImp=Zpi RenormImp=50ohm}}
  2: Wave Port Faces=sma_dielectric_2.face(3 of 3) NumModes=1 Modes{Mode1{IntLine{(0, 22.5, 14.8) -> (0, 22.5, 13.635)} CharImp=Zpi RenormImp=50ohm}}
setups:
  Setup1: HfssDriven Frequency=5.64GHz MaxDeltaS=0.02 MaximumPasses=10 MinimumPasses=1 MinimumConvergedPasses=1 PercentRefinement=30 BasisOrder=1 PortAccuracy=2 DrivenSolverType="Direct Solver"
    sweep Sweep: 4GHz to 8GHz, 401 points; Type=Interpolating InterpTolerance=0.5 InterpMaxSolns=250 InterpUsePortImped=false PassivityErrorTolerance=0.0001
source amplitudes:
  1:1: 10W 0deg
  2:1: 3.1W 90deg
radiation setups:
  Infinite Sphere1: Infinite Sphere Theta=0deg..180deg step 2deg Phi=-180deg..180deg step 2deg
  Box1: Near Box  Length=150mm Width=150mm LengthSamples=21 WidthSamples=21 CoordSystem=RelativeCS3 Height=200mm HeightSamples=21
field calculator expressions:
  Ex = Vector_E | ScalarX
  Ey = Vector_E | ScalarY
  Ez = Vector_E | ScalarZ
field plots:
  Vector_E1_atom_box: E Field over atom_box.face(+z) on Setup1 : LastAdaptive at Freq=5.64GHz Phase=0deg
  Vector_E2_atom_location: E Field on Setup1 : LastAdaptive at Freq=5.64GHz Phase=0deg
reports:
  Calculator Expressions Plot 1: Ey vs Ex on Setup1 : LastAdaptive [Phase=all Freq=5.64GHz]
  Calculator Expressions Plot 2: Ez vs Phase on Setup1 : LastAdaptive [Freq=5.64GHz]
  Gain Plot 1: GainTotal vs Phi, Theta on Setup1 : LastAdaptive, Infinite Sphere1 [Freq=5.64GHz]
  Near E Plot 1: NearETotal vs _v, _u on Setup1 : LastAdaptive [_t=-100mm Freq=5.64GHz]
  S Parameter Plot 1: dB(S(1,1)) vs Freq on Setup1 : Sweep
  S Parameter Plot 2: dB(S(2,2)) vs Freq on Setup1 : Sweep
  S Parameter Plot 3: dB(S(2,1)) vs Freq on Setup1 : Sweep
